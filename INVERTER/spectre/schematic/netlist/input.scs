// Design: 22301/INVERTER
simulator lang=spectre
global 0
include "/home/install/FOUNDRY/analog/90nm/libs.oa22/gpdk090/../../models/spectre/gpdk090.scs" section=NN

// 22301/INVERTER/schematic
NM0 (OUT net1 0 0) gpdk090_nmos1v w=(120n) l=100n m=(1)*(1) simM=(1)*(1)
PM0 (OUT net1 net2 net2) gpdk090_pmos1v w=(120n) l=100n m=(1)*(1) simM=(1)*(1)
V1 (net1 0) vsource dc=1.8 type=dc
V0 (net2 0) vsource dc=1.8 type=dc
simulatorOptions options temp=27
dcOp dc
dc dc dev=V1 param=dc start=0 stop=1.8
